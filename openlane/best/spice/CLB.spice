* NGSPICE file created from CLB.ext - technology: sky130A

* Black-box entry subcircuit for sky130_fd_sc_hd__dfxtp_1 abstract view
.subckt sky130_fd_sc_hd__dfxtp_1 CLK D VGND VNB VPB VPWR Q
.ends

* Black-box entry subcircuit for sky130_fd_sc_hd__fill_1 abstract view
.subckt sky130_fd_sc_hd__fill_1 VGND VNB VPB VPWR
.ends

* Black-box entry subcircuit for sky130_fd_sc_hd__mux2_1 abstract view
.subckt sky130_fd_sc_hd__mux2_1 A0 A1 S VGND VNB VPB VPWR X
.ends

* Black-box entry subcircuit for sky130_fd_sc_hd__buf_2 abstract view
.subckt sky130_fd_sc_hd__buf_2 A VGND VNB VPB VPWR X
.ends

* Black-box entry subcircuit for sky130_fd_sc_hd__tapvpwrvgnd_1 abstract view
.subckt sky130_fd_sc_hd__tapvpwrvgnd_1 VGND VPWR
.ends

* Black-box entry subcircuit for sky130_fd_sc_hd__decap_3 abstract view
.subckt sky130_fd_sc_hd__decap_3 VGND VNB VPB VPWR
.ends

* Black-box entry subcircuit for sky130_fd_sc_hd__a31oi_1 abstract view
.subckt sky130_fd_sc_hd__a31oi_1 A1 A2 A3 B1 VGND VNB VPB VPWR Y
.ends

* Black-box entry subcircuit for sky130_fd_sc_hd__a21oi_1 abstract view
.subckt sky130_fd_sc_hd__a21oi_1 A1 A2 B1 VGND VNB VPB VPWR Y
.ends

* Black-box entry subcircuit for sky130_fd_sc_hd__fill_2 abstract view
.subckt sky130_fd_sc_hd__fill_2 VGND VNB VPB VPWR
.ends

* Black-box entry subcircuit for sky130_fd_sc_hd__mux4_1 abstract view
.subckt sky130_fd_sc_hd__mux4_1 A0 A1 A2 A3 S0 S1 VGND VNB VPB VPWR X
.ends

* Black-box entry subcircuit for sky130_fd_sc_hd__clkbuf_4 abstract view
.subckt sky130_fd_sc_hd__clkbuf_4 A VGND VNB VPB VPWR X
.ends

* Black-box entry subcircuit for sky130_fd_sc_hd__mux4_2 abstract view
.subckt sky130_fd_sc_hd__mux4_2 A0 A1 A2 A3 S0 S1 VGND VNB VPB VPWR X
.ends

* Black-box entry subcircuit for sky130_ef_sc_hd__decap_12 abstract view
.subckt sky130_ef_sc_hd__decap_12 VPWR VGND VPB VNB
.ends

* Black-box entry subcircuit for sky130_fd_sc_hd__inv_2 abstract view
.subckt sky130_fd_sc_hd__inv_2 A VGND VNB VPB VPWR Y
.ends

* Black-box entry subcircuit for sky130_fd_sc_hd__buf_1 abstract view
.subckt sky130_fd_sc_hd__buf_1 A VGND VNB VPB VPWR X
.ends

* Black-box entry subcircuit for sky130_fd_sc_hd__decap_4 abstract view
.subckt sky130_fd_sc_hd__decap_4 VGND VNB VPB VPWR
.ends

* Black-box entry subcircuit for sky130_fd_sc_hd__clkbuf_16 abstract view
.subckt sky130_fd_sc_hd__clkbuf_16 A VGND VNB VPB VPWR X
.ends

* Black-box entry subcircuit for sky130_fd_sc_hd__decap_6 abstract view
.subckt sky130_fd_sc_hd__decap_6 VGND VNB VPB VPWR
.ends

* Black-box entry subcircuit for sky130_fd_sc_hd__clkbuf_1 abstract view
.subckt sky130_fd_sc_hd__clkbuf_1 A VGND VNB VPB VPWR X
.ends

* Black-box entry subcircuit for sky130_fd_sc_hd__clkbuf_2 abstract view
.subckt sky130_fd_sc_hd__clkbuf_2 A VGND VNB VPB VPWR X
.ends

* Black-box entry subcircuit for sky130_fd_sc_hd__o2bb2a_1 abstract view
.subckt sky130_fd_sc_hd__o2bb2a_1 A1_N A2_N B1 B2 VGND VNB VPB VPWR X
.ends

* Black-box entry subcircuit for sky130_fd_sc_hd__nand2_1 abstract view
.subckt sky130_fd_sc_hd__nand2_1 A B VGND VNB VPB VPWR Y
.ends

* Black-box entry subcircuit for sky130_fd_sc_hd__o22a_1 abstract view
.subckt sky130_fd_sc_hd__o22a_1 A1 A2 B1 B2 VGND VNB VPB VPWR X
.ends

* Black-box entry subcircuit for sky130_fd_sc_hd__a21o_1 abstract view
.subckt sky130_fd_sc_hd__a21o_1 A1 A2 B1 VGND VNB VPB VPWR X
.ends

* Black-box entry subcircuit for sky130_fd_sc_hd__o21a_1 abstract view
.subckt sky130_fd_sc_hd__o21a_1 A1 A2 B1 VGND VNB VPB VPWR X
.ends

* Black-box entry subcircuit for sky130_fd_sc_hd__decap_8 abstract view
.subckt sky130_fd_sc_hd__decap_8 VGND VNB VPB VPWR
.ends

* Black-box entry subcircuit for sky130_fd_sc_hd__and2b_1 abstract view
.subckt sky130_fd_sc_hd__and2b_1 A_N B VGND VNB VPB VPWR X
.ends

.subckt CLB VGND VPWR carry_in carry_out clk clk_out horz_bus_in[0] horz_bus_in[1]
+ horz_bus_in[2] horz_bus_in[3] horz_bus_out[0] horz_bus_out[1] horz_bus_out[2] horz_bus_out[3]
+ reset reset_out shift_clk shift_clk_out shift_data_in shift_data_out vert_bus_in[0]
+ vert_bus_in[1] vert_bus_in[2] vert_bus_in[3] vert_bus_out[0] vert_bus_out[1] vert_bus_out[2]
+ vert_bus_out[3]
X_83_ net28 major_horz3_sel\[1\] VGND VGND VPWR VPWR major_horz3_sel\[2\] sky130_fd_sc_hd__dfxtp_1
XFILLER_3_23 VGND VGND VPWR VPWR sky130_fd_sc_hd__fill_1
X_66_ net27 lut\[1\] VGND VGND VPWR VPWR lut\[2\] sky130_fd_sc_hd__dfxtp_1
X_49_ _18_ _16_ major_horz2_sel\[2\] VGND VGND VPWR VPWR net17 sky130_fd_sc_hd__mux2_1
Xoutput20 net20 VGND VGND VPWR VPWR shift_clk_out sky130_fd_sc_hd__buf_2
XTAP_TAPCELL_ROW_2_35 VGND VPWR sky130_fd_sc_hd__tapvpwrvgnd_1
X_65_ net27 lut\[0\] VGND VGND VPWR VPWR lut\[1\] sky130_fd_sc_hd__dfxtp_1
XPHY_EDGE_ROW_12_Right_12 VGND VGND VPWR VPWR sky130_fd_sc_hd__decap_3
X_82_ net28 major_horz3_sel\[0\] VGND VGND VPWR VPWR major_horz3_sel\[1\] sky130_fd_sc_hd__dfxtp_1
X_48_ _03_ major_horz2_sel\[0\] major_horz2_sel\[1\] _17_ VGND VGND VPWR VPWR _18_
+ sky130_fd_sc_hd__a31oi_1
Xoutput21 net21 VGND VGND VPWR VPWR shift_data_out sky130_fd_sc_hd__buf_2
XPHY_EDGE_ROW_6_Right_6 VGND VGND VPWR VPWR sky130_fd_sc_hd__decap_3
XTAP_TAPCELL_ROW_12_45 VGND VPWR sky130_fd_sc_hd__tapvpwrvgnd_1
X_81_ net28 major_horz2_sel\[2\] VGND VGND VPWR VPWR major_horz3_sel\[0\] sky130_fd_sc_hd__dfxtp_1
X_64_ net27 input_mux_c_sel\[1\] VGND VGND VPWR VPWR lut\[0\] sky130_fd_sc_hd__dfxtp_1
XFILLER_9_57 VGND VGND VPWR VPWR sky130_fd_sc_hd__fill_1
X_47_ net11 major_horz2_sel\[1\] major_horz2_sel\[0\] VGND VGND VPWR VPWR _17_ sky130_fd_sc_hd__a21oi_1
Xoutput22 net22 VGND VGND VPWR VPWR vert_bus_out[0] sky130_fd_sc_hd__buf_2
X_80_ net28 major_horz2_sel\[1\] VGND VGND VPWR VPWR major_horz2_sel\[2\] sky130_fd_sc_hd__dfxtp_1
X_63_ net26 input_mux_c_sel\[0\] VGND VGND VPWR VPWR input_mux_c_sel\[1\] sky130_fd_sc_hd__dfxtp_1
XPHY_EDGE_ROW_12_Left_28 VGND VGND VPWR VPWR sky130_fd_sc_hd__decap_3
XFILLER_0_38 VGND VGND VPWR VPWR sky130_fd_sc_hd__fill_2
X_46_ _15_ net12 operation_ff net5 major_horz2_sel\[1\] major_horz2_sel\[0\] VGND
+ VGND VPWR VPWR _16_ sky130_fd_sc_hd__mux4_1
Xoutput23 net23 VGND VGND VPWR VPWR vert_bus_out[1] sky130_fd_sc_hd__buf_2
X_29_ net3 net4 input_mux_b_sel VGND VGND VPWR VPWR _05_ sky130_fd_sc_hd__mux2_1
XPHY_EDGE_ROW_15_Left_31 VGND VGND VPWR VPWR sky130_fd_sc_hd__decap_3
XPHY_EDGE_ROW_0_Left_16 VGND VGND VPWR VPWR sky130_fd_sc_hd__decap_3
X_62_ net26 input_mux_b_sel VGND VGND VPWR VPWR input_mux_c_sel\[0\] sky130_fd_sc_hd__dfxtp_1
Xclkload0 clknet_1_1__leaf_clk VGND VGND VPWR VPWR clkload0/X sky130_fd_sc_hd__clkbuf_4
X_45_ operation_ff net10 minor_vert_sel\[3\] VGND VGND VPWR VPWR net25 sky130_fd_sc_hd__mux2_1
XTAP_TAPCELL_ROW_5_38 VGND VPWR sky130_fd_sc_hd__tapvpwrvgnd_1
X_28_ net4 net9 net5 net1 input_mux_c_sel\[1\] input_mux_c_sel\[0\] VGND VGND VPWR
+ VPWR _04_ sky130_fd_sc_hd__mux4_2
Xoutput24 net24 VGND VGND VPWR VPWR vert_bus_out[2] sky130_fd_sc_hd__buf_2
Xoutput13 net13 VGND VGND VPWR VPWR carry_out sky130_fd_sc_hd__buf_2
XFILLER_6_38 VGND VGND VPWR VPWR sky130_fd_sc_hd__fill_1
X_61_ net27 input_mux_a_sel VGND VGND VPWR VPWR input_mux_b_sel sky130_fd_sc_hd__dfxtp_1
XFILLER_1_3 VPWR VGND VPWR VGND sky130_ef_sc_hd__decap_12
XFILLER_3_6 VGND VGND VPWR VPWR sky130_fd_sc_hd__fill_1
X_44_ _15_ net9 minor_vert_sel\[2\] VGND VGND VPWR VPWR net24 sky130_fd_sc_hd__mux2_1
XTAP_TAPCELL_ROW_15_48 VGND VPWR sky130_fd_sc_hd__tapvpwrvgnd_1
X_27_ net4 VGND VGND VPWR VPWR _03_ sky130_fd_sc_hd__inv_2
Xoutput14 net14 VGND VGND VPWR VPWR clk_out sky130_fd_sc_hd__buf_1
Xoutput25 net25 VGND VGND VPWR VPWR vert_bus_out[3] sky130_fd_sc_hd__buf_2
X_60_ net27 net8 VGND VGND VPWR VPWR input_mux_a_sel sky130_fd_sc_hd__dfxtp_1
XFILLER_9_39 VGND VGND VPWR VPWR sky130_fd_sc_hd__fill_1
XFILLER_4_61 VGND VGND VPWR VPWR sky130_fd_sc_hd__fill_1
X_26_ net6 VGND VGND VPWR VPWR _02_ sky130_fd_sc_hd__inv_2
X_43_ operation_ff net12 minor_vert_sel\[1\] VGND VGND VPWR VPWR net23 sky130_fd_sc_hd__mux2_1
XTAP_TAPCELL_ROW_15_49 VGND VPWR sky130_fd_sc_hd__tapvpwrvgnd_1
Xoutput15 net15 VGND VGND VPWR VPWR horz_bus_out[0] sky130_fd_sc_hd__buf_2
XPHY_EDGE_ROW_1_Right_1 VGND VGND VPWR VPWR sky130_fd_sc_hd__decap_3
X_42_ _15_ net11 minor_vert_sel\[0\] VGND VGND VPWR VPWR net22 sky130_fd_sc_hd__mux2_1
XFILLER_1_52 VGND VGND VPWR VPWR sky130_fd_sc_hd__decap_4
XPHY_EDGE_ROW_7_Left_23 VGND VGND VPWR VPWR sky130_fd_sc_hd__decap_3
X_25_ net5 VGND VGND VPWR VPWR _01_ sky130_fd_sc_hd__inv_2
XPHY_EDGE_ROW_15_Right_15 VGND VGND VPWR VPWR sky130_fd_sc_hd__decap_3
XFILLER_15_39 VGND VGND VPWR VPWR sky130_fd_sc_hd__fill_1
Xclkbuf_0_clk clk VGND VGND VPWR VPWR clknet_0_clk sky130_fd_sc_hd__clkbuf_16
Xoutput16 net16 VGND VGND VPWR VPWR horz_bus_out[1] sky130_fd_sc_hd__buf_2
XFILLER_12_29 VGND VGND VPWR VPWR sky130_fd_sc_hd__fill_1
X_41_ _15_ net3 minor_horz_sel\[1\] VGND VGND VPWR VPWR net16 sky130_fd_sc_hd__mux2_1
Xoutput17 net17 VGND VGND VPWR VPWR horz_bus_out[2] sky130_fd_sc_hd__buf_2
XTAP_TAPCELL_ROW_0_32 VGND VPWR sky130_fd_sc_hd__tapvpwrvgnd_1
X_40_ _15_ net2 minor_horz_sel\[0\] VGND VGND VPWR VPWR net15 sky130_fd_sc_hd__mux2_1
XFILLER_10_41 VGND VGND VPWR VPWR sky130_fd_sc_hd__fill_1
Xoutput18 net18 VGND VGND VPWR VPWR horz_bus_out[3] sky130_fd_sc_hd__buf_2
XPHY_EDGE_ROW_5_Right_5 VGND VGND VPWR VPWR sky130_fd_sc_hd__decap_3
XFILLER_7_31 VGND VGND VPWR VPWR sky130_fd_sc_hd__decap_3
XTAP_TAPCELL_ROW_9_42 VGND VPWR sky130_fd_sc_hd__tapvpwrvgnd_1
XTAP_TAPCELL_ROW_0_33 VGND VPWR sky130_fd_sc_hd__tapvpwrvgnd_1
Xoutput19 net19 VGND VGND VPWR VPWR reset_out sky130_fd_sc_hd__buf_2
XPHY_EDGE_ROW_11_Right_11 VGND VGND VPWR VPWR sky130_fd_sc_hd__decap_3
XTAP_TAPCELL_ROW_10_43 VGND VPWR sky130_fd_sc_hd__tapvpwrvgnd_1
XPHY_EDGE_ROW_11_Left_27 VGND VGND VPWR VPWR sky130_fd_sc_hd__decap_3
XPHY_EDGE_ROW_14_Left_30 VGND VGND VPWR VPWR sky130_fd_sc_hd__decap_3
XFILLER_13_10 VGND VGND VPWR VPWR sky130_fd_sc_hd__fill_2
XFILLER_1_57 VGND VGND VPWR VPWR sky130_fd_sc_hd__decap_6
Xinput1 carry_in VGND VGND VPWR VPWR net1 sky130_fd_sc_hd__clkbuf_1
XPHY_EDGE_ROW_9_Right_9 VGND VGND VPWR VPWR sky130_fd_sc_hd__decap_3
Xinput2 horz_bus_in[0] VGND VGND VPWR VPWR net2 sky130_fd_sc_hd__clkbuf_1
X_79_ net26 major_horz2_sel\[0\] VGND VGND VPWR VPWR major_horz2_sel\[1\] sky130_fd_sc_hd__dfxtp_1
XTAP_TAPCELL_ROW_3_36 VGND VPWR sky130_fd_sc_hd__tapvpwrvgnd_1
XFILLER_1_15 VGND VGND VPWR VPWR sky130_fd_sc_hd__decap_4
X_78_ net26 minor_vert_sel\[3\] VGND VGND VPWR VPWR major_horz2_sel\[0\] sky130_fd_sc_hd__dfxtp_1
Xinput3 horz_bus_in[1] VGND VGND VPWR VPWR net3 sky130_fd_sc_hd__buf_1
XPHY_EDGE_ROW_0_Right_0 VGND VGND VPWR VPWR sky130_fd_sc_hd__decap_3
XTAP_TAPCELL_ROW_13_46 VGND VPWR sky130_fd_sc_hd__tapvpwrvgnd_1
X_77_ net26 minor_vert_sel\[2\] VGND VGND VPWR VPWR minor_vert_sel\[3\] sky130_fd_sc_hd__dfxtp_1
XPHY_EDGE_ROW_3_Left_19 VGND VGND VPWR VPWR sky130_fd_sc_hd__decap_3
Xinput4 horz_bus_in[2] VGND VGND VPWR VPWR net4 sky130_fd_sc_hd__buf_1
XPHY_EDGE_ROW_6_Left_22 VGND VGND VPWR VPWR sky130_fd_sc_hd__decap_3
Xfanout26 net28 VGND VGND VPWR VPWR net26 sky130_fd_sc_hd__clkbuf_2
XFILLER_8_7 VGND VGND VPWR VPWR sky130_fd_sc_hd__decap_4
Xinput5 horz_bus_in[3] VGND VGND VPWR VPWR net5 sky130_fd_sc_hd__buf_1
X_76_ net26 minor_vert_sel\[1\] VGND VGND VPWR VPWR minor_vert_sel\[2\] sky130_fd_sc_hd__dfxtp_1
X_59_ clknet_1_0__leaf_clk _00_ VGND VGND VPWR VPWR operation_ff sky130_fd_sc_hd__dfxtp_1
XFILLER_14_3 VGND VGND VPWR VPWR sky130_fd_sc_hd__fill_1
Xfanout27 net28 VGND VGND VPWR VPWR net27 sky130_fd_sc_hd__clkbuf_2
XFILLER_5_60 VGND VGND VPWR VPWR sky130_fd_sc_hd__fill_2
XPHY_EDGE_ROW_14_Right_14 VGND VGND VPWR VPWR sky130_fd_sc_hd__decap_3
X_58_ _23_ _24_ _02_ net21 VGND VGND VPWR VPWR _00_ sky130_fd_sc_hd__o2bb2a_1
XFILLER_10_27 VGND VGND VPWR VPWR sky130_fd_sc_hd__fill_1
Xinput6 reset VGND VGND VPWR VPWR net6 sky130_fd_sc_hd__buf_1
X_75_ net26 minor_vert_sel\[0\] VGND VGND VPWR VPWR minor_vert_sel\[1\] sky130_fd_sc_hd__dfxtp_1
XTAP_TAPCELL_ROW_6_39 VGND VPWR sky130_fd_sc_hd__tapvpwrvgnd_1
XPHY_EDGE_ROW_4_Right_4 VGND VGND VPWR VPWR sky130_fd_sc_hd__decap_3
Xfanout28 net7 VGND VGND VPWR VPWR net28 sky130_fd_sc_hd__clkbuf_2
XFILLER_4_29 VGND VGND VPWR VPWR sky130_fd_sc_hd__fill_2
Xinput7 shift_clk VGND VGND VPWR VPWR net7 sky130_fd_sc_hd__clkbuf_1
XFILLER_1_19 VGND VGND VPWR VPWR sky130_fd_sc_hd__fill_1
X_74_ net26 minor_horz_sel\[1\] VGND VGND VPWR VPWR minor_vert_sel\[0\] sky130_fd_sc_hd__dfxtp_1
XFILLER_5_50 VGND VGND VPWR VPWR sky130_fd_sc_hd__fill_1
XFILLER_6_6 VGND VGND VPWR VPWR sky130_fd_sc_hd__decap_4
X_57_ _01_ operation_ff net6 VGND VGND VPWR VPWR _24_ sky130_fd_sc_hd__a21oi_1
Xinput10 vert_bus_in[1] VGND VGND VPWR VPWR net10 sky130_fd_sc_hd__clkbuf_1
XFILLER_13_28 VGND VGND VPWR VPWR sky130_fd_sc_hd__decap_6
Xinput8 shift_data_in VGND VGND VPWR VPWR net8 sky130_fd_sc_hd__clkbuf_1
X_73_ net26 minor_horz_sel\[0\] VGND VGND VPWR VPWR minor_horz_sel\[1\] sky130_fd_sc_hd__dfxtp_1
X_56_ net5 _15_ VGND VGND VPWR VPWR _23_ sky130_fd_sc_hd__nand2_1
Xclkbuf_1_0__f_clk clknet_0_clk VGND VGND VPWR VPWR clknet_1_0__leaf_clk sky130_fd_sc_hd__clkbuf_16
X_39_ _07_ _11_ _14_ _10_ VGND VGND VPWR VPWR _15_ sky130_fd_sc_hd__o22a_1
XPHY_EDGE_ROW_10_Left_26 VGND VGND VPWR VPWR sky130_fd_sc_hd__decap_3
Xinput11 vert_bus_in[2] VGND VGND VPWR VPWR net11 sky130_fd_sc_hd__buf_1
XFILLER_7_19 VPWR VGND VPWR VGND sky130_ef_sc_hd__decap_12
XTAP_TAPCELL_ROW_7_40 VGND VPWR sky130_fd_sc_hd__tapvpwrvgnd_1
XFILLER_10_19 VGND VGND VPWR VPWR sky130_fd_sc_hd__fill_1
Xinput9 vert_bus_in[0] VGND VGND VPWR VPWR net9 sky130_fd_sc_hd__clkbuf_1
X_72_ net26 lut\[7\] VGND VGND VPWR VPWR minor_horz_sel\[0\] sky130_fd_sc_hd__dfxtp_1
X_55_ _05_ _09_ _22_ VGND VGND VPWR VPWR net13 sky130_fd_sc_hd__a21o_1
XPHY_EDGE_ROW_10_Right_10 VGND VGND VPWR VPWR sky130_fd_sc_hd__decap_3
Xinput12 vert_bus_in[3] VGND VGND VPWR VPWR net12 sky130_fd_sc_hd__buf_1
X_38_ _12_ _13_ _05_ VGND VGND VPWR VPWR _14_ sky130_fd_sc_hd__mux2_1
XPHY_EDGE_ROW_8_Right_8 VGND VGND VPWR VPWR sky130_fd_sc_hd__decap_3
X_54_ _05_ _09_ _04_ VGND VGND VPWR VPWR _22_ sky130_fd_sc_hd__o21a_1
X_71_ net27 lut\[6\] VGND VGND VPWR VPWR lut\[7\] sky130_fd_sc_hd__dfxtp_1
X_37_ lut\[6\] lut\[7\] _04_ VGND VGND VPWR VPWR _13_ sky130_fd_sc_hd__mux2_1
XFILLER_2_3 VGND VGND VPWR VPWR sky130_fd_sc_hd__decap_8
X_70_ net27 lut\[5\] VGND VGND VPWR VPWR lut\[6\] sky130_fd_sc_hd__dfxtp_1
XFILLER_5_43 VGND VGND VPWR VPWR sky130_fd_sc_hd__fill_2
XFILLER_2_11 VGND VGND VPWR VPWR sky130_fd_sc_hd__fill_1
XFILLER_2_33 VGND VGND VPWR VPWR sky130_fd_sc_hd__fill_1
X_53_ _21_ _19_ major_horz3_sel\[2\] VGND VGND VPWR VPWR net18 sky130_fd_sc_hd__mux2_1
X_36_ lut\[4\] lut\[5\] _04_ VGND VGND VPWR VPWR _12_ sky130_fd_sc_hd__mux2_1
XFILLER_5_55 VGND VGND VPWR VPWR sky130_fd_sc_hd__fill_1
X_52_ _01_ major_horz3_sel\[0\] major_horz3_sel\[1\] _20_ VGND VGND VPWR VPWR _21_
+ sky130_fd_sc_hd__a31oi_1
XTAP_TAPCELL_ROW_1_34 VGND VPWR sky130_fd_sc_hd__tapvpwrvgnd_1
XPHY_EDGE_ROW_2_Left_18 VGND VGND VPWR VPWR sky130_fd_sc_hd__decap_3
XFILLER_11_65 VGND VGND VPWR VPWR sky130_fd_sc_hd__fill_1
X_35_ _05_ _08_ _09_ VGND VGND VPWR VPWR _11_ sky130_fd_sc_hd__a21o_1
XPHY_EDGE_ROW_5_Left_21 VGND VGND VPWR VPWR sky130_fd_sc_hd__decap_3
XFILLER_8_11 VGND VGND VPWR VPWR sky130_fd_sc_hd__fill_1
XTAP_TAPCELL_ROW_11_44 VGND VPWR sky130_fd_sc_hd__tapvpwrvgnd_1
X_51_ net12 major_horz3_sel\[1\] major_horz3_sel\[0\] VGND VGND VPWR VPWR _20_ sky130_fd_sc_hd__a21oi_1
X_34_ _09_ VGND VGND VPWR VPWR _10_ sky130_fd_sc_hd__inv_2
X_33_ net2 net3 input_mux_a_sel VGND VGND VPWR VPWR _09_ sky130_fd_sc_hd__mux2_1
X_50_ _15_ operation_ff net11 net4 major_horz3_sel\[0\] major_horz3_sel\[1\] VGND
+ VGND VPWR VPWR _19_ sky130_fd_sc_hd__mux4_1
Xclkbuf_1_1__f_clk clknet_0_clk VGND VGND VPWR VPWR clknet_1_1__leaf_clk sky130_fd_sc_hd__clkbuf_16
XFILLER_14_45 VGND VGND VPWR VPWR sky130_fd_sc_hd__fill_1
XPHY_EDGE_ROW_3_Right_3 VGND VGND VPWR VPWR sky130_fd_sc_hd__decap_3
X_32_ lut\[2\] lut\[3\] _04_ VGND VGND VPWR VPWR _08_ sky130_fd_sc_hd__mux2_1
XPHY_EDGE_ROW_9_Left_25 VGND VGND VPWR VPWR sky130_fd_sc_hd__decap_3
XTAP_TAPCELL_ROW_4_37 VGND VPWR sky130_fd_sc_hd__tapvpwrvgnd_1
XPHY_EDGE_ROW_13_Right_13 VGND VGND VPWR VPWR sky130_fd_sc_hd__decap_3
X_31_ _05_ _06_ VGND VGND VPWR VPWR _07_ sky130_fd_sc_hd__and2b_1
XTAP_TAPCELL_ROW_14_47 VGND VPWR sky130_fd_sc_hd__tapvpwrvgnd_1
XFILLER_0_60 VGND VGND VPWR VPWR sky130_fd_sc_hd__fill_2
X_30_ lut\[0\] lut\[1\] _04_ VGND VGND VPWR VPWR _06_ sky130_fd_sc_hd__mux2_1
XFILLER_8_27 VGND VGND VPWR VPWR sky130_fd_sc_hd__fill_1
XPHY_EDGE_ROW_7_Right_7 VGND VGND VPWR VPWR sky130_fd_sc_hd__decap_3
XFILLER_2_29 VGND VGND VPWR VPWR sky130_fd_sc_hd__decap_4
XPHY_EDGE_ROW_13_Left_29 VGND VGND VPWR VPWR sky130_fd_sc_hd__decap_3
XFILLER_5_19 VGND VGND VPWR VPWR sky130_fd_sc_hd__decap_8
XFILLER_11_29 VGND VGND VPWR VPWR sky130_fd_sc_hd__fill_2
XFILLER_9_6 VGND VGND VPWR VPWR sky130_fd_sc_hd__decap_4
XPHY_EDGE_ROW_1_Left_17 VGND VGND VPWR VPWR sky130_fd_sc_hd__decap_3
X_87_ net28 VGND VGND VPWR VPWR net20 sky130_fd_sc_hd__clkbuf_1
XPHY_EDGE_ROW_4_Left_20 VGND VGND VPWR VPWR sky130_fd_sc_hd__decap_3
XFILLER_6_63 VGND VGND VPWR VPWR sky130_fd_sc_hd__decap_3
X_86_ net6 VGND VGND VPWR VPWR net19 sky130_fd_sc_hd__clkbuf_1
XFILLER_11_19 VGND VGND VPWR VPWR sky130_fd_sc_hd__decap_4
X_69_ net27 lut\[4\] VGND VGND VPWR VPWR lut\[5\] sky130_fd_sc_hd__dfxtp_1
XTAP_TAPCELL_ROW_8_41 VGND VPWR sky130_fd_sc_hd__tapvpwrvgnd_1
XFILLER_0_32 VGND VGND VPWR VPWR sky130_fd_sc_hd__decap_3
XFILLER_15_3 VGND VGND VPWR VPWR sky130_fd_sc_hd__fill_1
X_85_ clknet_1_1__leaf_clk VGND VGND VPWR VPWR net14 sky130_fd_sc_hd__buf_2
X_68_ net27 lut\[3\] VGND VGND VPWR VPWR lut\[4\] sky130_fd_sc_hd__dfxtp_1
XFILLER_9_20 VGND VGND VPWR VPWR sky130_fd_sc_hd__fill_1
XPHY_EDGE_ROW_2_Right_2 VGND VGND VPWR VPWR sky130_fd_sc_hd__decap_3
X_84_ net28 major_horz3_sel\[2\] VGND VGND VPWR VPWR net21 sky130_fd_sc_hd__dfxtp_1
XFILLER_3_55 VGND VGND VPWR VPWR sky130_fd_sc_hd__fill_1
X_67_ net27 lut\[2\] VGND VGND VPWR VPWR lut\[3\] sky130_fd_sc_hd__dfxtp_1
XFILLER_9_10 VGND VGND VPWR VPWR sky130_fd_sc_hd__fill_1
XPHY_EDGE_ROW_8_Left_24 VGND VGND VPWR VPWR sky130_fd_sc_hd__decap_3
.ends
